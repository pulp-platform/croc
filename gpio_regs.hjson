{
    name: "gpio"
    clock_primary: "clk_i"
    reset_primary: "rst_ni"
    param_list: [
        {
            name: GPIOCount
            default: "32"
        }
    ]
    bus_interfaces: [
        { protocol: "reg_iface", direction: "device"}
    ]
    regwidth: 32,
    registers: [
        {
            name: "INFO"
            desc: "Info register that contains information about this peripheral."
            swaccess: "ro",
            hwaccess: "hwo",
            hwext: true
            fields: [
                {
                    name: "GPIO_CNT"
                    bits: "9:0"
                    desc: "Contains the number of GPIOs controlled by this peripheral."
                }
                {
                    name: "VERSION"
                    bits: "19:10"
                    desc: "The version number of the IPs."
                    resval: 2
                }
            ]
        }
        {skipto: "0x080"}
        { multireg:
          { name: "GPIO_EN",
            cname: "GPIO_EN",
            count: "GPIOCount",
            compact: true,
            desc: "Enable sampling on the corresponding GPIO",
            swaccess: "rw",
            hwaccess: "hro",
            fields: [
                {
                    bits: "0"
                }
            ]
          }
        }
        {skipto: "0x100"}
        { multireg:
          { name: "GPIO_IN",
            cname: "GPIO_IN",
            count: "GPIOCount",
            compact: true,
            desc: "Read the current input values of all GPIOs."
            swaccess: "ro",
            hwaccess: "hwo",
            hwext: true
            fields: [
                {
                    bits: "0"
                }
            ]
          }
        }
        {skipto: "0x180"}
        { multireg:
          { name: "GPIO_OUT",
            cname: "GPIO_OUT",
            count: "GPIOCount",
            compact: true,
            desc: "Set the output value of the corresponding GPIOs."
            swaccess: "rw",
            hwaccess: "hrw",
            fields: [
                {
                    bits: "0"
                }
            ]
          }
        }
        {skipto: "0x300"}
        { multireg:
          { name: "GPIO_TOGGLE",
            cname: "GPIO_TOGGLE",
            count: "GPIOCount",
            compact: true
            desc: "For each asserted bit in this register, toggle the corresponding bit in the padout register."
            swaccess: "wo",
            hwaccess: "hro",
            hwqe: true,
            hwext: true,
            fields: [
                {
                    bits: "0"
                }
            ]
          }
        }
    ]
}
