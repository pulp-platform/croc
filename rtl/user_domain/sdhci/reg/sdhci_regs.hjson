{
  #"human_name": SD Host Controller ver1.00 Registers
  name: "sdhci"
  clock_primary: "clk_i"
  reset_primary: "rst_ni"
  bus_interfaces: [
    {
      protocol: "reg_iface"
      direction: "device"
    }
  ]
  regwidth: 32
  interrupt_list: []
  registers: [
    {
      name: "system_address"
      hwaccess: "hrw"
      fields: [
        {
          bits: "31:0"
          name: "dma_system_address"
          swaccess: "rw"
        }
      ]
    }
    {
      packed: [
        {
          name: "block_size"
          hwaccess: "hrw"
          fields: [
            {
              bits: "15"
              name: "rsvd_15"
              swaccess: "ro"
              hwaccess: "hro"
              resval: "0"
            }
            {
              bits: "14:12"
              name: "host_dma_buffer_boundary"
              swaccess: "rw"
            }
            {
              bits: "11:0"
              name: "transfer_block_size"
              swaccess: "rw"
            }
          ]
        }
        {
          name: "block_count"
          hwaccess: "hrw"
          fields: [
            {
              bits: "15:0"
              name: "blocks_count_for_current_transfer"
              swaccess: "rw"
            }
          ]
        }
      ]
    }
    {
      name: "argument"
      hwaccess: "hrw"
      fields: [
        {
          bits: "31:0"
          name: "command_argument"
          swaccess: "rw"
        }
      ]
    }
    {
      packed: [
        {
          name: "transfer_mode"
          hwaccess: "hrw"
          fields: [
            {
              bits: "15:6"
              name: "rsvd_6"
              swaccess: "ro"
              hwaccess: "hro"
              resval: "0"
            }
            {
              bits: "5"
              name: "multi_single_bit_block_select"
              swaccess: "rw"
            }
            {
              bits: "4"
              name: "data_transfer_direction_select"
              swaccess: "rw"
            }
            {
              bits: "3"
              name: "rsvd_3"
              swaccess: "ro"
              hwaccess: "hro"
              resval: "0"
            }
            {
              bits: "2"
              name: "auto_cmd12_enable"
              swaccess: "rw"
            }
            {
              bits: "1"
              name: "block_count_enable"
              swaccess: "rw"
            }
            {
              bits: "0"
              name: "dma_enable"
              swaccess: "rw"
            }
          ]
        }
        {
          name: "command"
          hwaccess: "hrw"
          hwqe: true
          fields: [
            {
              bits: "15:14"
              name: "rsvd_14"
              swaccess: "ro"
              hwaccess: "hro"
              resval: "0"
            }
            {
              bits: "13:8"
              name: "command_index"
              swaccess: "rw"
            }
            {
              bits: "7:6"
              name: "command_type"
              swaccess: "rw"
            }
            {
              bits: "5"
              name: "data_present_select"
              swaccess: "rw"
            }
            {
              bits: "4"
              name: "command_index_check_enable"
              swaccess: "rw"
            }
            {
              bits: "3"
              name: "command_crc_check_enable"
              swaccess: "rw"
            }
            {
              bits: "2"
              name: "rsvd_2"
              swaccess: "ro"
              hwaccess: "hro"
              resval: "0"
            }
            {
              bits: "1:0"
              name: "response_type_select"
              swaccess: "rw"
            }
          ]
        }
      ]
    }
    {
      name: "response0"
            // "spans": 4
      hwaccess: "hrw"
      // "hwqe": true
      fields: [
        {
          bits: "31:0"
          name: "response"
          swaccess: "ro"
          resval: "0"
        }
      ]
    }
    {
      name: "response1"
      hwaccess: "hrw"
      fields: [
        {
          bits: "31:0"
          name: "response"
          swaccess: "ro"
          resval: "0"
        }
      ]
    }
    {
      name: "response2"
      hwaccess: "hrw"
      fields: [
        {
          bits: "31:0"
          name: "response"
          swaccess: "ro"
          resval: "0"
        }
      ]
    }
    {
      name: "response3"
      hwaccess: "hrw"
      fields: [
        {
          bits: "31:0"
          name: "response"
          swaccess: "ro"
          resval: "0"
        }
      ]
    }
    {
      name: "buffer_data_port"
      hwaccess: "hrw"
      fields: [
        {
          bits: "31:0"
          name: "buffer_data"
          swaccess: "rw"
        }
      ]
    }
    {
      name: "present_state"
      swaccess: "ro"
      resval: "0"
      hwaccess: "hrw"
      fields: [
        {
          bits: "15:12"
          name: "rsvd_12"
          swaccess: "ro"
          hwaccess: "hro"
          resval: "0"
        }
        {
          bits: "11"
          name: "buffer_read_enable"
        }
        {
          bits: "10"
          name: "buffer_write_enable"
        }
        {
          bits: "9"
          name: "read_transfer_active"
        }
        {
          bits: "8"
          name: "write_transfer_active"
        }
        {
          bits: "7:3"
          name: "rsvd_3"
          swaccess: "ro"
          hwaccess: "hro"
          resval: "0"
        }
        {
          bits: "2"
          name: "dat_line_active"
        }
        {
          bits: "1"
          name: "command_inhibit_dat"
        }
        {
          bits: "0"
          name: "command_inhibit_cmd"
        }
        {
          bits: "31:25"
          name: "rsvd_25"
          swaccess: "ro"
          hwaccess: "hro"
          resval: "0"
        }
        {
          bits: "24"
          name: "cmd_line_signal_level"
        }
        {
          bits: "23:20"
          name: "dat_line_signal_level"
        }
        {
          bits: "19"
          name: "write_protect_switch_pin_level"
        }
        {
          bits: "18"
          name: "card_detect_pin_level"
        }
        {
          bits: "17"
          name: "card_state_stable"
        }
        {
          bits: "16"
          name: "card_inserted"
        }
      ]
    }
    {
      packed: [
        {
          name: "host_control"
          swaccess: "rw"
          hwaccess: "hrw"
          fields: [
            {
              bits: "7:3"
              name: "rsvd_3"
              swaccess: "ro"
              hwaccess: "hro"
              resval: "0"
            }
            {
              bits: "2"
              name: "high_speed_enable"
            }
            {
              bits: "1"
              name: "data_transfer_width"
            }
            {
              bits: "0"
              name: "led_control"
            }
          ]
        }
        {
          name: "power_control"
          swaccess: "rw"
          hwaccess: "hrw"
          fields: [
            {
              bits: "7:4"
              name: "rsvd_4"
              swaccess: "ro"
              hwaccess: "hro"
              resval: "0"
            }
            {
              bits: "3:1"
              name: "sd_bus_voltage_select"
            }
            {
              bits: "0"
              name: "sd_bus_power"
            }
          ]
        }
        {
          name: "block_gap_control"
          hwaccess: "hrw"
          fields: [
            {
              bits: "7:4"
              name: "rsvd_4"
              swaccess: "ro"
              hwaccess: "hro"
              resval: "0"
            }
            {
              bits: "3"
              name: "interrupt_at_block_gap"
              swaccess: "rw"
            }
            {
              bits: "2"
              name: "read_wait_control"
              swaccess: "rw"
            }
            {
              bits: "1"
              name: "continue_request"
              swaccess: "rw1s"
            }
            {
              bits: "0"
              name: "stop_at_block_gap_request"
              swaccess: "rw"
            }
          ]
        }
        {
          name: "wakeup_control"
          swaccess: "rw"
          hwaccess: "hrw"
          fields: [
            {
              bits: "7:3"
              name: "rsvd_3"
              swaccess: "ro"
              hwaccess: "hro"
              resval: "0"
            }
            {
              bits: "2"
              name: "wakeup_event_enable_on_sd_card_removal"
              swaccess: "rw"
            }
            {
              bits: "1"
              name: "wakeup_event_enable_on_sd_card_insertion"
              swaccess: "rw"
            }
            {
              bits: "0"
              name: "wakeup_event_enable_on_card_interrupt"
              swaccess: "rw"
            }
          ]
        }
      ]
    }
    {
      packed: [
        {
          name: "clock_control"
          hwaccess: "hrw"
          fields: [
            {
              bits: "15:8"
              name: "sdclk_frequency_select"
              swaccess: "rw"
            }
            {
              bits: "7:3"
              name: "rsvd_3"
              swaccess: "ro"
              hwaccess: "hro"
              resval: "0"
            }
            {
              bits: "2"
              name: "sd_clock_enable"
              swaccess: "rw"
            }
            {
              bits: "1"
              name: "internal_clock_stable"
              swaccess: "ro"
              resval: "0"
            }
            {
              bits: "0"
              name: "internal_clock_enable"
              swaccess: "rw"
            }
          ]
        }
        {
          name: "timeout_control"
          hwaccess: "hrw"
          fields: [
            {
              bits: "7:4"
              name: "rsvd_4"
              swaccess: "ro"
              hwaccess: "hro"
              resval: "0"
            }
            {
              bits: "3:0"
              name: "data_timeout_counter_value"
              swaccess: "rw"
            }
          ]
        }
        {
          name: "software_reset"
          hwaccess: "hrw"
          fields: [
            {
              bits: "7:4"
              name: "rsvd_4"
              swaccess: "ro"
              hwaccess: "hro"
              resval: "0"
            }
            {
              bits: "2"
              name: "software_reset_for_dat_line"
              swaccess: "rw1s"
            }
            {
              bits: "1"
              name: "software_reset_for_cmd_line"
              swaccess: "rw1s"
            }
            {
              bits: "0"
              name: "software_reset_for_all"
              swaccess: "rw1s"
            }
          ]
        }
      ]
    }
    {
      packed: [
        {
          name: "normal_interrupt_status"
          hwaccess: "hrw"
          fields: [
            {
              bits: "15"
              name: "error_interrupt"
              swaccess: "ro"
              resval: "0"
            }
            {
              bits: "14:9"
              name: "rsvd_9"
              swaccess: "ro"
              hwaccess: "hro"
              resval: "0"
            }
            {
              bits: "8"
              name: "card_interrupt"
              swaccess: "ro"
              resval: "0"
            }
            {
              bits: "7"
              name: "card_removal"
              swaccess: "rw1c"
            }
            {
              bits: "6"
              name: "card_insertion"
              swaccess: "rw1c"
            }
            {
              bits: "5"
              name: "buffer_read_ready"
              swaccess: "rw1c"
            }
            {
              bits: "4"
              name: "buffer_write_ready"
              swaccess: "rw1c"
            }
            {
              bits: "3"
              name: "dma_interrupt"
              swaccess: "rw1c"
            }
            {
              bits: "2"
              name: "block_gap_event"
              swaccess: "rw1c"
            }
            {
              bits: "1"
              name: "transfer_complete"
              swaccess: "rw1c"
            }
            {
              bits: "0"
              name: "command_complete"
              swaccess: "rw1c"
            }
          ]
        }
        {
          name: "error_interrupt_status"
          swaccess: "rw1c"
          hwaccess: "hrw"
          fields: [
            {
              bits: "15:12"
              name: "vendor_specific_error_status"
            }
            {
              bits: "11:9"
              name: "rsvd_9"
              swaccess: "ro"
              hwaccess: "hro"
              resval: "0"
            }
            {
              bits: "8"
              name: "auto_cmd12_error"
            }
            {
              bits: "7"
              name: "current_limit_error"
            }
            {
              bits: "6"
              name: "data_end_bit_error"
            }
            {
              bits: "5"
              name: "data_crc_error"
            }
            {
              bits: "4"
              name: "data_timeout_error"
            }
            {
              bits: "3"
              name: "command_index_error"
            }
            {
              bits: "2"
              name: "command_end_bit_error"
            }
            {
              bits: "1"
              name: "command_crc_error"
            }
            {
              bits: "0"
              name: "command_timeout_error"
            }
          ]
        }
      ]
    }
    {
      packed: [
        {
          name: "normal_interrupt_status_enable"
          hwaccess: "hrw"
          fields: [
            {
              bits: "15"
              name: "fixed_to_0"
              swaccess: "ro"
              resval: "0"
            }
            {
              bits: "14:9"
              name: "rsvd_9"
              swaccess: "ro"
              hwaccess: "hro"
              resval: "0"
            }
            {
              bits: "8"
              name: "card_interrupt_status_enable"
              swaccess: "rw"
            }
            {
              bits: "7"
              name: "card_removal_status_enable"
              swaccess: "rw"
            }
            {
              bits: "6"
              name: "card_insertion_status_enable"
              swaccess: "rw"
            }
            {
              bits: "5"
              name: "buffer_read_ready_status_enable"
              swaccess: "rw"
            }
            {
              bits: "4"
              name: "buffer_write_ready_status_enable"
              swaccess: "rw"
            }
            {
              bits: "3"
              name: "dma_interrupt_status_enable"
              swaccess: "rw"
            }
            {
              bits: "2"
              name: "block_gap_event_status_enable"
              swaccess: "rw"
            }
            {
              bits: "1"
              name: "transfer_complete_status_enable"
              swaccess: "rw"
            }
            {
              bits: "0"
              name: "command_complete_status_enable"
              swaccess: "rw"
            }
          ]
        }
        {
          name: "error_interrupt_status_enable"
          swaccess: "rw"
          hwaccess: "hrw"
          fields: [
            {
              bits: "15:12"
              name: "vendor_specific_error_status_enable"
            }
            {
              bits: "11:9"
              name: "rsvd_9"
              swaccess: "ro"
              hwaccess: "hro"
              resval: "0"
            }
            {
              bits: "8"
              name: "auto_cmd12_error_status_enable"
            }
            {
              bits: "7"
              name: "current_limit_error_status_enable"
            }
            {
              bits: "6"
              name: "data_end_bit_error_status_enable"
            }
            {
              bits: "5"
              name: "data_crc_error_status_enable"
            }
            {
              bits: "4"
              name: "data_timeout_error_status_enable"
            }
            {
              bits: "3"
              name: "command_index_error_status_enable"
            }
            {
              bits: "2"
              name: "command_end_bit_error_status_enable"
            }
            {
              bits: "1"
              name: "command_crc_error_status_enable"
            }
            {
              bits: "0"
              name: "command_timeout_error_status_enable"
            }
          ]
        }
      ]
    }
    {
      packed: [
        {
          name: "normal_interrupt_signal_enable"
          hwaccess: "hrw"
          fields: [
            {
              bits: "15"
              name: "fixed_to_0"
              swaccess: "ro"
              resval: "0"
            }
            {
              bits: "14:9"
              name: "rsvd_9"
              swaccess: "ro"
              hwaccess: "hro"
              resval: "0"
            }
            {
              bits: "8"
              name: "card_interrupt_signal_enable"
              swaccess: "rw"
            }
            {
              bits: "7"
              name: "card_removal_signal_enable"
              swaccess: "rw"
            }
            {
              bits: "6"
              name: "card_insertion_signal_enable"
              swaccess: "rw"
            }
            {
              bits: "5"
              name: "buffer_read_ready_signal_enable"
              swaccess: "rw"
            }
            {
              bits: "4"
              name: "buffer_write_ready_signal_enable"
              swaccess: "rw"
            }
            {
              bits: "3"
              name: "dma_interrupt_signal_enable"
              swaccess: "rw"
            }
            {
              bits: "2"
              name: "block_gap_event_signal_enable"
              swaccess: "rw"
            }
            {
              bits: "1"
              name: "transfer_complete_signal_enable"
              swaccess: "rw"
            }
            {
              bits: "0"
              name: "command_complete_signal_enable"
              swaccess: "rw"
            }
          ]
        }
        {
          name: "error_interrupt_signal_enable"
          swaccess: "rw"
          hwaccess: "hrw"
          fields: [
            {
              bits: "15:12"
              name: "vendor_specific_error_signal_enable"
            }
            {
              bits: "11:9"
              name: "rsvd_9"
              swaccess: "ro"
              hwaccess: "hro"
              resval: "0"
            }
            {
              bits: "8"
              name: "auto_cmd12_error_signal_enable"
            }
            {
              bits: "7"
              name: "current_limit_error_signal_enable"
            }
            {
              bits: "6"
              name: "data_end_bit_error_signal_enable"
            }
            {
              bits: "5"
              name: "data_crc_error_signal_enable"
            }
            {
              bits: "4"
              name: "data_timeout_error_signal_enable"
            }
            {
              bits: "3"
              name: "command_index_error_signal_enable"
            }
            {
              bits: "2"
              name: "command_end_bit_error_signal_enable"
            }
            {
              bits: "1"
              name: "command_crc_error_signal_enable"
            }
            {
              bits: "0"
              name: "command_timeout_error_signal_enable"
            }
          ]
        }
      ]
    }
    {
      name: "auto_cmd12_error_status"
      swaccess: "ro"
      resval: "0"
      hwaccess: "hrw"
      fields: [
        {
          bits: "15:8"
          name: "rsvd_8"
          swaccess: "ro"
          hwaccess: "hro"
          resval: "0"
        }
        {
          bits: "7"
          name: "command_not_issued_by_auto_cmd12_error"
        }
        {
          bits: "6:5"
          name: "rsvd_5"
          swaccess: "ro"
          hwaccess: "hro"
          resval: "0"
        }
        {
          bits: "4"
          name: "auto_cmd12_index_error"
        }
        {
          bits: "3"
          name: "auto_cmd12_end_bit_error"
        }
        {
          bits: "2"
          name: "auto_cmd12_crc_error"
        }
        {
          bits: "1"
          name: "auto_cmd12_timeout_error"
        }
        {
          bits: "0"
          name: "auto_cmd12_not_executed"
        }
      ]
    }
    {
      name: "capabilities"
      swaccess: "ro"
      hwaccess: "hrw"
      hwaccess: "hrw"
      fields: [
        {
          bits: "31:27"
          name: "rsvd_27"
          swaccess: "ro"
          hwaccess: "hro"
          resval: "0"
        }
        {
          bits: "26"
          name: "voltage_support_1_8v"
        }
        {
          bits: "25"
          name: "voltage_support_3_0v"
        }
        {
          bits: "24"
          name: "voltage_support_3_3v"
        }
        {
          bits: "23"
          name: "suspend_resume_support"
        }
        {
          bits: "22"
          name: "dma_support"
        }
        {
          bits: "21"
          name: "high_speed_support"
        }
        {
          bits: "20:18"
          name: "rsvd_18"
          swaccess: "ro"
          hwaccess: "hro"
          resval: "0"
        }
        {
          bits: "17:16"
          name: "max_block_length"
        }
        {
          bits: "15:14"
          name: "rsvd_14"
          swaccess: "ro"
          hwaccess: "hro"
          resval: "0"
        }
        {
          bits: "13:8"
          name: "base_clock_frequency_for_sd_clock"
        }
        {
          bits: "7"
          name: "timeout_clock_unit"
        }
        {
          bits: "6"
          name: "rsvd_6"
          swaccess: "ro"
          hwaccess: "hro"
          resval: "0"
        }
        {
          bits: "5:0"
          name: "timeout_clock_frequency"
        }
      ]
    }
    // Capabilities (Reserved)
    {
      reserved: 1
    }
    {
      name: "maximum_current_capabilities"
      swaccess: "ro"
      hwaccess: "hro"
      fields: [
        {
          bits: "31:24"
          name: "rsvd_24"
          swaccess: "ro"
          hwaccess: "hro"
          resval: "0"
        }
        {
          bits: "23:16"
          name: "maximum_current_for_1_8v"
        }
        {
          bits: "15:8"
          name: "maximum_current_for_3_0v"
        }
        {
          bits: "7:0"
          name: "maximum_current_for_3_3v"
        }
      ]
    }
    // Maximum Current Capabilities (Reserved)
    {
      reserved: 1
    }


    // Unused
    {
      reserved: 41
    }

    // Shared Registry Area
    {
      reserved: 2
    }
    {
      packed: [
        {
          name: "slot_interrupt_status_register"
          swaccess: "ro"
          resval: "0"
          hwaccess: "hrw"
          fields: [
            {
              bits: "15:8"
              name: "rsvd_8"
              swaccess: "ro"
              hwaccess: "hro"
              resval: "0"
            }
            {
              bits: "7:0"
              name: "interrupt_signal_for_each_slot"
            }
          ]
        }
        {
          name: "host_controller_version_register"
          swaccess: "ro"
          hwaccess: "hrw"
          fields: [
            {
              bits: "15:8"
              name: "vendor_version_number"
              resval: "0"
            }
            {
              bits: "7:0"
              name: "specification_version_number"
              resval: "0"
            }
          ]
        }
      ]
    }
  ]
}